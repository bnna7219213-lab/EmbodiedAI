* B1 攀岩腱驱动关节板 (TendonDrive-Climbing)
* Auto-generated by EdaLab core (edalab.core.cgen.SpiceNetlist)
* components=27 wires=46

* (跳过非仿真元件: J_PWR CONNECTOR)
CCBULK1 N1 0 0.000470000
CCBULK2 N1 0 1.00000e-07
* (跳过非仿真元件: U_GATE IC)
* (跳过非仿真元件: Q1 MOSFET)
* (跳过非仿真元件: Q2 MOSFET)
* (跳过非仿真元件: Q3 MOSFET)
* (跳过非仿真元件: Q4 MOSFET)
* (跳过非仿真元件: Q5 MOSFET)
* (跳过非仿真元件: Q6 MOSFET)
* (跳过非仿真元件: U_CS1 IC)
* (跳过非仿真元件: U_CS2 IC)
* (跳过非仿真元件: U_MCU IC)
* (跳过非仿真元件: U_CAN IC)
* (跳过非仿真元件: U_ENC IC)
* (跳过非仿真元件: U_LC0 IC)
* (跳过非仿真元件: U_LC1 IC)
* (跳过非仿真元件: U_LC2 IC)
* (跳过非仿真元件: U_LC3 IC)
* (跳过非仿真元件: U_LC4 IC)
* (跳过非仿真元件: U_LC5 IC)
* (跳过非仿真元件: U_LC6 IC)
* (跳过非仿真元件: U_LC7 IC)
* (跳过非仿真元件: J_MOT CONNECTOR)
* (跳过非仿真元件: J_CAN CONNECTOR)
* (跳过非仿真元件: J_ENC CONNECTOR)

.end
