* EDA-AFE-IND 桥式微弱信号采集前端(应变/热电偶/RTD)
* Auto-generated by EdaLab core (edalab.core.cgen.SpiceNetlist)
* components=67 wires=100

VVRAW N1 0 DC 12.0000
LFB1 N1 N2 1.00000e-05
CCBULK N2 0 1.00000e-05
CCCER N2 0 1.00000e-07
VVREG N3 0 DC 5.00000
EU_LDO N4 0 N3 N4 1e5
* (跳过非仿真元件: AVCC CONNECTOR)
RRSTAR 0 0 0
CCAVDD1 N4 0 1.00000e-07
CCAVDD2 N4 0 1.00000e-05
VVCM N6 0 DC 2.50000
VVEXC N7 0 DC 5.00000
EUEXC N6 0 N7 N6 1e5
RRTOP N6 N8 1000.00
RBR1 N8 N9 350.000
RBR2 N9 N10 350.000
RBR3 N8 N11 350.000
RBR4 N11 N10 350.000
* (跳过非仿真元件: BHI CONNECTOR)
* (跳过非仿真元件: BLO CONNECTOR)
* (跳过非仿真元件: BMS1 CONNECTOR)
* (跳过非仿真元件: BMS2 CONNECTOR)
VVSTRAIN N9 N11 DC 0.00500000
DDESD1 N8 N4 D1N4148
DDESD2 0 N8 D1N4148
DDESD3 N10 N4 D1N4148
DDESD4 0 N10 D1N4148
RRIN1 N8 N9 100.000
RRIN2 N10 N11 100.000
CCIN1 N9 0 1.00000e-10
CCIN2 N11 0 1.00000e-10
EIU1 N17 0 N9 N16 1e5
EIU2 N19 0 N11 N18 1e5
EIU3 N22 0 N20 N21 1e5
RIR1A N16 N17 200000
RIR1B N18 N19 200000
RIRG N16 N18 2000.00
RIR3A N17 N21 10000.0
RIR4A N21 N22 10000.0
RIR3B N19 N20 10000.0
RIR4B N20 N6 10000.0
RRTRIM N22 N6 50000.0
EUPGA N24 0 N22 N23 1e5
RRFP N24 N23 10000.0
RRGP N23 N6 10000.0
* (跳过非仿真元件: TCJ CONNECTOR)
DDTEMP 0 N27 D1N4148
EUCJC N29 0 N28 N29 1e5
RRCJC N27 N28 10000.0
EIULP N31 0 N30 N31 1e5
RIRA N24 N32 15000.0
RIRB N32 N30 15000.0
CIC1 N32 N6 1.00000e-09
CIC2 N30 N31 1.00000e-09
EIOUTP N34 0 N31 N33 1e5
RROF N34 N33 10000.0
RROG N33 N6 10000.0
CCLOAD N34 N35 0.000100000
* (跳过非仿真元件: VOUT CONNECTOR)
RRL N35 0 1000.00
* (跳过非仿真元件: TP_EXC CONNECTOR)
* (跳过非仿真元件: TP_BR CONNECTOR)
* (跳过非仿真元件: TP_OUT CONNECTOR)
* (跳过非仿真元件: CAL CONNECTOR)
RRCAL N40 N22 100000

.model D1N4148 D(IS=1e-14 N=1.8)

.end
